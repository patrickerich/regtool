{
    name: "uart",
    regwidth: 32,
    
    registers: [
        {
            name: "CTRL",
            desc: "Control Register",
            swaccess: "rw",
            offset: "0x00",
            fields: [
                {
                    bits: "0",
                    name: "TX_EN",
                    desc: "Transmitter Enable"
                },
                {
                    bits: "1",
                    name: "RX_EN", 
                    desc: "Receiver Enable"
                }
            ]
        },
        {
            name: "STATUS",
            desc: "Status Register",
            swaccess: "ro",
            offset: "0x04", 
            fields: [
                {
                    bits: "0",
                    name: "TX_FULL",
                    desc: "TX FIFO Full"
                },
                {
                    bits: "1",
                    name: "RX_EMPTY",
                    desc: "RX FIFO Empty"
                }
            ]
        }
    ]
}
